* EXTRA x2: revision 2
V1 in 0 DC 1
R1 in n1 1k
R3 n1 out 1k
.end
