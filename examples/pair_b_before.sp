* pair_b: revision 1 — 改版前
V1 in 0 DC 1
R1 in n1 1k
R2 n1 out 2k
C1 n1 0 10p
D1 out 0 DMOD
.model DMOD D(IS=1e-14 N=1)
.end
