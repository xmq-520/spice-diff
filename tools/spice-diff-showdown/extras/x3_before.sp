* EXTRA x3: revision 1
.global vdd
V1 vdd 0 DC 1
R1 vdd n1 1k
R2 n1 out 1k
.end
