* EXTRA x3: revision 2
.global vdd
V1 vdd 0 DC 1
R1 vdd n1 1k
R2 n1 out 2k
R4 out vdd 100k
.end
