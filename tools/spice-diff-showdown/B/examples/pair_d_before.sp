* pair_d: 身份不可判定的用例 —— 两个完全相同的并联电阻
* R1 与 R2 同为 1k、连同两个节点，签名完全一致
V1 in 0 DC 1
R1 in out 1k
R2 in out 1k
.end
