* pair_d: 删掉其中一个并联电阻 —— 但删的是 R1 还是 R2，文本上无从判定
V1 in 0 DC 1
R2 in out 1k
.end
